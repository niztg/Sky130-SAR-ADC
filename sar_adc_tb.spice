* 10-bit SAR ADC top-level testbench  --  bottom-plate sampling
*
* Signal flow:
*   vin --(bootstrap inside CDAC)--> bottom plates during SAMPLE (phi_s high)
*   top plate vdac reset to vcm (0.9V) during SAMPLE
*   convert: vdac = vcm - vin + (D/1024)*vref
*   comparator: VIN1=vcm, VIN2=vdac  -> Y high when vdac < vcm  (keep bit)
*   Y --(DFF on clkbar = clk falling edge)--> comp_in --> SAR logic
*
* Expected code for vin = 0.6V :  D = round(0.6/1.8 * 1024) = 341 = 0101010101

.lib /Users/nizansari/.volare/sky130A/libs.tech/ngspice/sky130.lib.spice tt
.include "/Users/nizansari/Desktop/Projects/SAR ADC/sar_logic_fixed.spice"
.include "/Users/nizansari/Desktop/Projects/SAR ADC/cdac.spice"

* -------------------------
* Comparator subcircuit  (verified block, port order: VDD X Y CLK VIN2 VIN1)
*   evaluates while CLK is HIGH, precharges X,Y high while CLK is LOW
* -------------------------
.subckt strongarm_comparator VDD X Y CLK VIN2 VIN1
XS1 P CLK VDD VDD sky130_fd_pr__pfet_01v8 L=0.15 W=1 nf=1 ad='int((nf+1)/2) * W/nf * 0.29' as='int((nf+2)/2) * W/nf * 0.29' pd='2*int((nf+1)/2) * (W/nf + 0.29)' ps='2*int((nf+2)/2) * (W/nf + 0.29)' nrd='0.29 / W' nrs='0.29 / W' sa=0 sb=0 sd=0 mult=1
XS3 X CLK VDD VDD sky130_fd_pr__pfet_01v8 L=0.15 W=1 nf=1 ad='int((nf+1)/2) * W/nf * 0.29' as='int((nf+2)/2) * W/nf * 0.29' pd='2*int((nf+1)/2) * (W/nf + 0.29)' ps='2*int((nf+2)/2) * (W/nf + 0.29)' nrd='0.29 / W' nrs='0.29 / W' sa=0 sb=0 sd=0 mult=1
XM5 X Y VDD VDD sky130_fd_pr__pfet_01v8 L=0.15 W=4 nf=1 ad='int((nf+1)/2) * W/nf * 0.29' as='int((nf+2)/2) * W/nf * 0.29' pd='2*int((nf+1)/2) * (W/nf + 0.29)' ps='2*int((nf+2)/2) * (W/nf + 0.29)' nrd='0.29 / W' nrs='0.29 / W' sa=0 sb=0 sd=0 mult=1
XM6 Y X VDD VDD sky130_fd_pr__pfet_01v8 L=0.15 W=4 nf=1 ad='int((nf+1)/2) * W/nf * 0.29' as='int((nf+2)/2) * W/nf * 0.29' pd='2*int((nf+1)/2) * (W/nf + 0.29)' ps='2*int((nf+2)/2) * (W/nf + 0.29)' nrd='0.29 / W' nrs='0.29 / W' sa=0 sb=0 sd=0 mult=1
XS4 Y CLK VDD VDD sky130_fd_pr__pfet_01v8 L=0.15 W=1 nf=1 ad='int((nf+1)/2) * W/nf * 0.29' as='int((nf+2)/2) * W/nf * 0.29' pd='2*int((nf+1)/2) * (W/nf + 0.29)' ps='2*int((nf+2)/2) * (W/nf + 0.29)' nrd='0.29 / W' nrs='0.29 / W' sa=0 sb=0 sd=0 mult=1
XS2 Q CLK VDD VDD sky130_fd_pr__pfet_01v8 L=0.15 W=1 nf=1 ad='int((nf+1)/2) * W/nf * 0.29' as='int((nf+2)/2) * W/nf * 0.29' pd='2*int((nf+1)/2) * (W/nf + 0.29)' ps='2*int((nf+2)/2) * (W/nf + 0.29)' nrd='0.29 / W' nrs='0.29 / W' sa=0 sb=0 sd=0 mult=1
XM4 Y X Q 0 sky130_fd_pr__nfet_01v8 L=0.15 W=4 nf=1 ad='int((nf+1)/2) * W/nf * 0.29' as='int((nf+2)/2) * W/nf * 0.29' pd='2*int((nf+1)/2) * (W/nf + 0.29)' ps='2*int((nf+2)/2) * (W/nf + 0.29)' nrd='0.29 / W' nrs='0.29 / W' sa=0 sb=0 sd=0 mult=1
XM3 X Y P 0 sky130_fd_pr__nfet_01v8 L=0.15 W=4 nf=1 ad='int((nf+1)/2) * W/nf * 0.29' as='int((nf+2)/2) * W/nf * 0.29' pd='2*int((nf+1)/2) * (W/nf + 0.29)' ps='2*int((nf+2)/2) * (W/nf + 0.29)' nrd='0.29 / W' nrs='0.29 / W' sa=0 sb=0 sd=0 mult=1
XM1 P VIN1 net1 0 sky130_fd_pr__nfet_01v8 L=0.15 W=8 nf=1 ad='int((nf+1)/2) * W/nf * 0.29' as='int((nf+2)/2) * W/nf * 0.29' pd='2*int((nf+1)/2) * (W/nf + 0.29)' ps='2*int((nf+2)/2) * (W/nf + 0.29)' nrd='0.29 / W' nrs='0.29 / W' sa=0 sb=0 sd=0 mult=1
XM2 Q VIN2 net1 0 sky130_fd_pr__nfet_01v8 L=0.15 W=8 nf=1 ad='int((nf+1)/2) * W/nf * 0.29' as='int((nf+2)/2) * W/nf * 0.29' pd='2*int((nf+1)/2) * (W/nf + 0.29)' ps='2*int((nf+2)/2) * (W/nf + 0.29)' nrd='0.29 / W' nrs='0.29 / W' sa=0 sb=0 sd=0 mult=1
XM7 net1 CLK 0 0 sky130_fd_pr__nfet_01v8 L=0.15 W=2 nf=1 ad='int((nf+1)/2) * W/nf * 0.29' as='int((nf+2)/2) * W/nf * 0.29' pd='2*int((nf+1)/2) * (W/nf + 0.29)' ps='2*int((nf+2)/2) * (W/nf + 0.29)' nrd='0.29 / W' nrs='0.29 / W' sa=0 sb=0 sd=0 mult=1
.ends strongarm_comparator

* -------------------------
* Supplies and references
* -------------------------
Vvdd vdd 0 DC 1.8
Vvref vref 0 DC 1.8
Vvcm vcm 0 DC 0.9
Vvin vin 0 DC 1.2

* -------------------------
* Clocks  (0.5 MHz -- deliberately slow so the CDAC settles inside the
*          ~990ns evaluate window; ~8 RC time-constants for the 12.8pF MSB
*          driven through the W=2 switches. Speed this back up later by
*          widening the upper-bit vref/gnd switches, not by touching timing.)
*   clk    : SAR FSM clock + comparator strobe (evaluate while HIGH)
*   clkbar : captures the comparator decision on clk's FALLING edge
* -------------------------
Vclk    clk    0 PULSE(0 1.8 500n 1n 1n 990n 2000n)
Vclkbar clkbar 0 PULSE(1.8 0 500n 1n 1n 990n 2000n)

* -------------------------
* Phase / control  (2us clock period)
*   phi_s  : LOW [0,100ns] FIRST, so the bootstrap gets a HOLD phase and its
*            flying cap C_boot precharges to VDD. THEN HIGH [100,400ns] to SAMPLE
*            (now the boost engages and vin_s = vin), then LOW to convert.
*            Starting phi_s high skipped the precharge -> boost never engaged ->
*            wrong sampled voltage (the gain/offset bug). The standalone bootstrap
*            TB hid this by free-running many cycles before anyone looked.
*   rst    : one brief pulse to initialise the SAR (active=0, cdac_sw=0)
*   start  : single pulse spanning the first clk edge (500ns) -> launches search
* -------------------------
Vphi_s phi_s 0 PULSE(0 1.8 100n 1n 1n 300n 100u)
Vrst   rst   0 PULSE(0 1.8 0   1n 1n 50n 100u)
Vstart start 0 PULSE(0 1.8 450n 1n 1n 200n 100u)

* -------------------------
* Block instantiations
* -------------------------

* CDAC (input sampling + bootstrap now live inside this block)
Xcdac vdac cdac_sw.9 cdac_sw.8 cdac_sw.7 cdac_sw.6 cdac_sw.5
+      cdac_sw.4 cdac_sw.3 cdac_sw.2 cdac_sw.1 cdac_sw.0
+      vref vdd 0 vin phi_s vcm cdac

* StrongARM comparator.  CRITICAL: strobe on clkbar (clk LOW), a half cycle
* AFTER the FSM updates the DAC on clk rising. The StrongARM samples its input
* at the strobe edge, so strobing on the same edge as the DAC update samples an
* unsettled vdac (this was the stuck-MSB bug). With clkbar, vdac settles during
* the clk-HIGH phase, then the comparator strobes the settled value.
* VIN2=vdac, VIN1=vcm  ->  comp_x low / comp_y high when vdac < vcm (keep)
Xcmp vdd comp_x comp_y clkbar vdac vcm strongarm_comparator

* SR latch (cross-coupled NAND) holds the decision through precharge, since the
* StrongARM resets comp_x,comp_y both high when not evaluating.
*   keep  (vdac<vcm): comp_x=0,comp_y=1 -> comp_in=1
*   clear (vdac>vcm): comp_x=1,comp_y=0 -> comp_in=0
* comp_in is stable across the next clk rising edge, so the SAR reads it directly.
Xsr_q    comp_x sr_qbar 0 0 vdd vdd comp_in  sky130_fd_sc_hd__nand2_1
Xsr_qbar comp_y comp_in 0 0 vdd vdd sr_qbar  sky130_fd_sc_hd__nand2_1

* SAR logic
Xsar clk rst start comp_in
+     cdac_sw.9 cdac_sw.8 cdac_sw.7 cdac_sw.6 cdac_sw.5
+     cdac_sw.4 cdac_sw.3 cdac_sw.2 cdac_sw.1 cdac_sw.0
+     result.9 result.8 result.7 result.6 result.5
+     result.4 result.3 result.2 result.1 result.0
+     done vdd 0 sar_logic

* -------------------------
* Simulation
* -------------------------
* conversion now finishes ~20.5us (start edge 500ns + 10 bits x 2us)
.tran 1n 22u

.probe v(vdac) v(comp_y) v(comp_in) v(clk) v(phi_s) v(done)
.probe v(cdac_sw.9) v(cdac_sw.8) v(cdac_sw.7) v(cdac_sw.6) v(cdac_sw.5)
.probe v(cdac_sw.4) v(cdac_sw.3) v(cdac_sw.2) v(cdac_sw.1) v(cdac_sw.0)
.probe v(result.9) v(result.8) v(result.7) v(result.6) v(result.5)
.probe v(result.4) v(result.3) v(result.2) v(result.1) v(result.0)

* Read the 10-bit output once the conversion has finished (done ~20.5us)
* result.N reads ~1.8V for a 1, ~0V for a 0.  Expected for vin=0.6V: 0101010101
.meas tran b9 find v(result.9) at=21.5u
.meas tran b8 find v(result.8) at=21.5u
.meas tran b7 find v(result.7) at=21.5u
.meas tran b6 find v(result.6) at=21.5u
.meas tran b5 find v(result.5) at=21.5u
.meas tran b4 find v(result.4) at=21.5u
.meas tran b3 find v(result.3) at=21.5u
.meas tran b2 find v(result.2) at=21.5u
.meas tran b1 find v(result.1) at=21.5u
.meas tran b0 find v(result.0) at=21.5u

.end

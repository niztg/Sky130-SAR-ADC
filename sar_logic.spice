* SPICE netlist generated by Yosys 0.66 (git sha1 7f8fdfd8d7bc08c749a2a969388d3425d4f369d5, clang++ 17.0.0 -fPIC -O3)

X0 cdac_sw.0 1 sky130_fd_sc_hd__clkinv_1
X1 bit_idx.3 2 sky130_fd_sc_hd__clkinv_1
X2 bit_idx.2 3 sky130_fd_sc_hd__clkinv_1
X3 active 4 sky130_fd_sc_hd__clkinv_1
X4 rst 5 sky130_fd_sc_hd__clkinv_1
X5 bit_idx.0 bit_idx.1 bit_idx.2 6 sky130_fd_sc_hd__nor3_1
X6 bit_idx.0 bit_idx.1 bit_idx.2 7 sky130_fd_sc_hd__or3_1
X7 bit_idx.3 bit_idx.0 bit_idx.1 bit_idx.2 8 sky130_fd_sc_hd__or4_1
X8 2 6 4 9 sky130_fd_sc_hd__a21oi_1
X9 active 8 10 sky130_fd_sc_hd__nand2_1
X10 bit_idx.1 bit_idx.0 11 sky130_fd_sc_hd__nand2b_1
X11 bit_idx.3 bit_idx.2 4 11 12 sky130_fd_sc_hd__or4_1
X12 active start 13 sky130_fd_sc_hd__nor2_1
X13 start active 14 sky130_fd_sc_hd__lpflow_isobufsrc_1
X14 4 start 15 sky130_fd_sc_hd__nand2_1
X15 active 6 16 sky130_fd_sc_hd__nand2_1
X16 4 8 17 sky130_fd_sc_hd__nor2_1
X17 14 17 18 sky130_fd_sc_hd__nor2_1
X18 1 12 14 17 19 sky130_fd_sc_hd__a211oi_1
X19 bit_idx.0 bit_idx.1 bit_idx.2 20 sky130_fd_sc_hd__o21ai_0
X20 2 comp_in 7 20 21 sky130_fd_sc_hd__nand4_1
X21 bit_idx.0 bit_idx.1 22 sky130_fd_sc_hd__nand2b_1
X22 bit_idx.2 22 23 sky130_fd_sc_hd__nor2_1
X23 2 23 21 11 24 sky130_fd_sc_hd__o2bb2ai_1
X24 cdac_sw.1 12 18 24 9 25 sky130_fd_sc_hd__a32o_1
X25 bit_idx.0 bit_idx.1 26 sky130_fd_sc_hd__nand2_1
X26 bit_idx.3 bit_idx.2 bit_idx.1 bit_idx.0 27 sky130_fd_sc_hd__nor4bb_1
X27 bit_idx.0 comp_in bit_idx.1 2 3 28 sky130_fd_sc_hd__o2111ai_1
X28 10 28 29 sky130_fd_sc_hd__nor2_1
X29 2 active 23 14 30 sky130_fd_sc_hd__a31oi_1
X30 8 13 31 sky130_fd_sc_hd__lpflow_inputiso1p_1
X31 cdac_sw.2 30 31 29 32 sky130_fd_sc_hd__a31o_1
X32 done 17 33 sky130_fd_sc_hd__nor2_1
X33 14 33 34 sky130_fd_sc_hd__nor2_1
X34 bit_idx.3 bit_idx.0 bit_idx.1 bit_idx.2 35 sky130_fd_sc_hd__nor4b_1
X35 comp_in 27 35 36 sky130_fd_sc_hd__a21oi_1
X36 active 27 14 37 sky130_fd_sc_hd__a21oi_1
X37 cdac_sw.3 31 37 38 sky130_fd_sc_hd__nand3_1
X38 10 36 38 39 sky130_fd_sc_hd__o21ai_0
X39 bit_idx.1 bit_idx.2 bit_idx.3 bit_idx.0 40 sky130_fd_sc_hd__nor4bb_1
X40 result.9 13 41 sky130_fd_sc_hd__nand2_1
X41 40 comp_in 42 sky130_fd_sc_hd__lpflow_isobufsrc_1
X42 result.9 40 active 43 sky130_fd_sc_hd__o21ai_0
X43 42 43 41 44 sky130_fd_sc_hd__o21ai_0
X44 bit_idx.3 bit_idx.2 active 45 sky130_fd_sc_hd__nand3b_1
X45 11 45 46 sky130_fd_sc_hd__nor2_1
X46 active comp_in 35 46 47 sky130_fd_sc_hd__a31oi_1
X47 active 35 14 48 sky130_fd_sc_hd__a21oi_1
X48 cdac_sw.4 31 48 49 sky130_fd_sc_hd__nand3_1
X49 47 49 50 sky130_fd_sc_hd__nand2_1
X50 42 10 4 cdac_sw.9 51 sky130_fd_sc_hd__a2bb2oi_1
X51 bit_idx.3 23 40 cdac_sw.9 52 sky130_fd_sc_hd__a211oi_1
X52 51 52 15 53 sky130_fd_sc_hd__o21ai_0
X53 14 46 54 sky130_fd_sc_hd__nor2_1
X54 comp_in 8 46 55 sky130_fd_sc_hd__and3_1
X55 22 45 56 sky130_fd_sc_hd__nor2_1
X56 cdac_sw.5 31 54 55 56 57 sky130_fd_sc_hd__a311o_1
X57 14 56 58 sky130_fd_sc_hd__nor2_1
X58 cdac_sw.6 31 59 sky130_fd_sc_hd__nand2_1
X59 26 45 60 sky130_fd_sc_hd__nor2_1
X60 comp_in 56 60 61 sky130_fd_sc_hd__a21oi_1
X61 14 56 59 61 62 sky130_fd_sc_hd__o31ai_1
X62 14 60 63 sky130_fd_sc_hd__nor2_1
X63 comp_in 60 64 sky130_fd_sc_hd__and2_0
X64 2 16 65 sky130_fd_sc_hd__nor2_1
X65 cdac_sw.7 31 63 64 65 66 sky130_fd_sc_hd__a311o_1
X66 10 15 67 sky130_fd_sc_hd__nand2_1
X67 bit_idx.3 16 68 sky130_fd_sc_hd__nand2_1
X68 15 68 69 sky130_fd_sc_hd__nand2_1
X69 bit_idx.3 comp_in 70 sky130_fd_sc_hd__nand2_1
X70 bit_idx.3 comp_in 6 40 71 sky130_fd_sc_hd__a31oi_1
X71 cdac_sw.8 15 16 72 sky130_fd_sc_hd__nand3_1
X72 10 71 72 73 sky130_fd_sc_hd__o21ai_0
X73 comp_in 17 18 result.0 74 sky130_fd_sc_hd__a22o_1
X74 result.1 12 15 75 sky130_fd_sc_hd__nand3_1
X75 4 11 21 75 76 sky130_fd_sc_hd__o31ai_1
X76 4 21 22 77 sky130_fd_sc_hd__nor3_1
X77 result.2 30 77 78 sky130_fd_sc_hd__a21o_1
X78 active comp_in 27 37 result.3 79 sky130_fd_sc_hd__a32o_1
X79 active comp_in 35 48 result.4 80 sky130_fd_sc_hd__a32o_1
X80 result.5 54 55 81 sky130_fd_sc_hd__a21o_1
X81 comp_in 56 58 result.6 82 sky130_fd_sc_hd__a22o_1
X82 result.7 63 64 83 sky130_fd_sc_hd__a21o_1
X83 result.8 15 84 sky130_fd_sc_hd__nand2_1
X84 16 70 84 65 85 sky130_fd_sc_hd__o22ai_1
X85 bit_idx.0 9 14 86 sky130_fd_sc_hd__nor3_1
X86 bit_idx.0 active 86 87 sky130_fd_sc_hd__a21oi_1
X87 bit_idx.1 10 15 88 sky130_fd_sc_hd__nand3_1
X88 9 11 22 89 sky130_fd_sc_hd__nand3_1
X89 88 89 90 sky130_fd_sc_hd__nand2_1
X90 7 20 10 91 sky130_fd_sc_hd__a21o_1
X91 3 67 91 92 sky130_fd_sc_hd__o21ai_0
X92 rst 93 sky130_fd_sc_hd__clkinv_1
X93 rst 94 sky130_fd_sc_hd__clkinv_1
X94 rst 95 sky130_fd_sc_hd__clkinv_1
X95 rst 96 sky130_fd_sc_hd__clkinv_1
X96 rst 97 sky130_fd_sc_hd__clkinv_1
X97 rst 98 sky130_fd_sc_hd__clkinv_1
X98 rst 99 sky130_fd_sc_hd__clkinv_1
X99 rst 100 sky130_fd_sc_hd__clkinv_1
X100 rst 101 sky130_fd_sc_hd__clkinv_1
X101 rst 102 sky130_fd_sc_hd__clkinv_1
X102 rst 103 sky130_fd_sc_hd__clkinv_1
X103 rst 104 sky130_fd_sc_hd__clkinv_1
X104 rst 105 sky130_fd_sc_hd__clkinv_1
X105 rst 106 sky130_fd_sc_hd__clkinv_1
X106 rst 107 sky130_fd_sc_hd__clkinv_1
X107 rst 108 sky130_fd_sc_hd__clkinv_1
X108 rst 109 sky130_fd_sc_hd__clkinv_1
X109 rst 110 sky130_fd_sc_hd__clkinv_1
X110 rst 111 sky130_fd_sc_hd__clkinv_1
X111 rst 112 sky130_fd_sc_hd__clkinv_1
X112 rst 113 sky130_fd_sc_hd__clkinv_1
X113 rst 114 sky130_fd_sc_hd__clkinv_1
X114 rst 115 sky130_fd_sc_hd__clkinv_1
X115 rst 116 sky130_fd_sc_hd__clkinv_1
X116 rst 117 sky130_fd_sc_hd__clkinv_1
X117 clkin 87 bit_idx.0 94 sky130_fd_sc_hd__dfstp_2
X118 clkin 90 bit_idx.1 93 sky130_fd_sc_hd__dfrtp_1
X119 clkin 92 bit_idx.2 5 sky130_fd_sc_hd__dfrtp_1
X120 clkin 69 bit_idx.3 106 sky130_fd_sc_hd__dfstp_2
X121 clkin 19 cdac_sw.0 117 sky130_fd_sc_hd__dfrtp_1
X122 clkin 25 cdac_sw.1 116 sky130_fd_sc_hd__dfrtp_1
X123 clkin 32 cdac_sw.2 115 sky130_fd_sc_hd__dfrtp_1
X124 clkin 39 cdac_sw.3 113 sky130_fd_sc_hd__dfrtp_1
X125 clkin 50 cdac_sw.4 111 sky130_fd_sc_hd__dfrtp_1
X126 clkin 57 cdac_sw.5 109 sky130_fd_sc_hd__dfrtp_1
X127 clkin 62 cdac_sw.6 108 sky130_fd_sc_hd__dfrtp_1
X128 clkin 66 cdac_sw.7 107 sky130_fd_sc_hd__dfrtp_1
X129 clkin 73 cdac_sw.8 105 sky130_fd_sc_hd__dfrtp_1
X130 clkin 53 cdac_sw.9 110 sky130_fd_sc_hd__dfrtp_1
X131 clkin 74 result.0 104 sky130_fd_sc_hd__dfrtp_1
X132 clkin 76 result.1 102 sky130_fd_sc_hd__dfrtp_1
X133 clkin 78 result.2 101 sky130_fd_sc_hd__dfrtp_1
X134 clkin 79 result.3 100 sky130_fd_sc_hd__dfrtp_1
X135 clkin 80 result.4 99 sky130_fd_sc_hd__dfrtp_1
X136 clkin 81 result.5 98 sky130_fd_sc_hd__dfrtp_1
X137 clkin 82 result.6 97 sky130_fd_sc_hd__dfrtp_1
X138 clkin 83 result.7 96 sky130_fd_sc_hd__dfrtp_1
X139 clkin 85 result.8 95 sky130_fd_sc_hd__dfrtp_1
X140 clkin 44 result.9 112 sky130_fd_sc_hd__dfrtp_1
X141 clkin 34 done 114 sky130_fd_sc_hd__dfrtp_1
X142 clkin 67 active 103 sky130_fd_sc_hd__dfrtp_1
V0 cdac_sw.0 118 DC 0
V1 19 119 DC 0
V2 cdac_sw.1 120 DC 0
V3 25 121 DC 0
V4 cdac_sw.2 122 DC 0
V5 32 123 DC 0
V6 done 124 DC 0
V7 34 125 DC 0
V8 cdac_sw.3 126 DC 0
V9 39 127 DC 0
V10 result.9 128 DC 0
V11 44 129 DC 0
V12 cdac_sw.4 130 DC 0
V13 50 131 DC 0
V14 cdac_sw.9 132 DC 0
V15 53 133 DC 0
V16 cdac_sw.5 134 DC 0
V17 57 135 DC 0
V18 cdac_sw.6 136 DC 0
V19 62 137 DC 0
V20 cdac_sw.7 138 DC 0
V21 66 139 DC 0
V22 bit_idx.3 140 DC 0
V23 67 141 DC 0
V24 69 142 DC 0
V25 cdac_sw.8 143 DC 0
V26 73 144 DC 0
V27 result.0 145 DC 0
V28 74 146 DC 0
V29 result.1 147 DC 0
V30 76 148 DC 0
V31 result.2 149 DC 0
V32 78 150 DC 0
V33 result.3 151 DC 0
V34 79 152 DC 0
V35 result.4 153 DC 0
V36 80 154 DC 0
V37 result.5 155 DC 0
V38 81 156 DC 0
V39 result.6 157 DC 0
V40 82 158 DC 0
V41 result.7 159 DC 0
V42 83 160 DC 0
V43 result.8 161 DC 0
V44 85 162 DC 0
V45 bit_idx.0 163 DC 0
V46 87 164 DC 0
V47 bit_idx.1 165 DC 0
V48 90 166 DC 0
V49 bit_idx.2 167 DC 0
V50 92 168 DC 0
V51 active 169 DC 0
V52 start 170 DC 0
V53 comp_in 171 DC 0
V54 rst 172 DC 0
V55 5 173 DC 0
V56 93 174 DC 0
V57 94 175 DC 0
V58 95 176 DC 0
V59 96 177 DC 0
V60 97 178 DC 0
V61 98 179 DC 0
V62 99 180 DC 0
V63 100 181 DC 0
V64 101 182 DC 0
V65 102 183 DC 0
V66 103 184 DC 0
V67 104 185 DC 0
V68 105 186 DC 0
V69 106 187 DC 0
V70 107 188 DC 0
V71 108 189 DC 0
V72 109 190 DC 0
V73 110 191 DC 0
V74 111 192 DC 0
V75 112 193 DC 0
V76 113 194 DC 0
V77 114 195 DC 0
V78 115 196 DC 0
V79 116 197 DC 0
V80 117 198 DC 0

************************
* end of SPICE netlist *
************************

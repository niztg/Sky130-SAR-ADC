.include "/Users/nizansari/.volare/sky130A/libs.ref/sky130_fd_sc_hd/spice/sky130_fd_sc_hd.spice"
* SAR logic SPICE netlist — fixed by fix_spice_ports.py
.subckt sar_logic clkin rst start comp_in cdac_sw.9 cdac_sw.8 cdac_sw.7 cdac_sw.6 cdac_sw.5 cdac_sw.4 cdac_sw.3 cdac_sw.2 cdac_sw.1 cdac_sw.0 result.9 result.8 result.7 result.6 result.5 result.4 result.3 result.2 result.1 result.0 done VDD GND

X0 cdac_sw.0 GND GND VDD VDD 1 sky130_fd_sc_hd__clkinv_1
X1 bit_idx.3 GND GND VDD VDD 2 sky130_fd_sc_hd__clkinv_1
X2 bit_idx.2 GND GND VDD VDD 3 sky130_fd_sc_hd__clkinv_1
X3 active GND GND VDD VDD 4 sky130_fd_sc_hd__clkinv_1
X4 rst GND GND VDD VDD 5 sky130_fd_sc_hd__clkinv_1
X5 bit_idx.0 bit_idx.1 bit_idx.2 GND GND VDD VDD 6 sky130_fd_sc_hd__nor3_1
X6 bit_idx.0 bit_idx.1 bit_idx.2 GND GND VDD VDD 7 sky130_fd_sc_hd__or3_1
X7 bit_idx.3 bit_idx.0 bit_idx.1 bit_idx.2 GND GND VDD VDD 8 sky130_fd_sc_hd__or4_1
X8 2 6 4 GND GND VDD VDD 9 sky130_fd_sc_hd__a21oi_1
X9 active 8 GND GND VDD VDD 10 sky130_fd_sc_hd__nand2_1
X10 bit_idx.1 bit_idx.0 GND GND VDD VDD 11 sky130_fd_sc_hd__nand2b_1
X11 bit_idx.3 bit_idx.2 4 11 GND GND VDD VDD 12 sky130_fd_sc_hd__or4_1
X12 active start GND GND VDD VDD 13 sky130_fd_sc_hd__nor2_1
X13 start active GND GND VDD VDD 14 sky130_fd_sc_hd__lpflow_isobufsrc_1
X14 4 start GND GND VDD VDD 15 sky130_fd_sc_hd__nand2_1
X15 active 6 GND GND VDD VDD 16 sky130_fd_sc_hd__nand2_1
X16 4 8 GND GND VDD VDD 17 sky130_fd_sc_hd__nor2_1
X17 14 17 GND GND VDD VDD 18 sky130_fd_sc_hd__nor2_1
X18 1 12 14 17 GND GND VDD VDD 19 sky130_fd_sc_hd__a211oi_1
X19 bit_idx.0 bit_idx.1 bit_idx.2 GND GND VDD VDD 20 sky130_fd_sc_hd__o21ai_0
X20 2 comp_in 7 20 GND GND VDD VDD 21 sky130_fd_sc_hd__nand4_1
X21 bit_idx.0 bit_idx.1 GND GND VDD VDD 22 sky130_fd_sc_hd__nand2b_1
X22 bit_idx.2 22 GND GND VDD VDD 23 sky130_fd_sc_hd__nor2_1
X23 2 23 21 11 GND GND VDD VDD 24 sky130_fd_sc_hd__o2bb2ai_1
X24 cdac_sw.1 12 18 24 9 GND GND VDD VDD 25 sky130_fd_sc_hd__a32o_1
X25 bit_idx.0 bit_idx.1 GND GND VDD VDD 26 sky130_fd_sc_hd__nand2_1
X26 bit_idx.3 bit_idx.2 bit_idx.1 bit_idx.0 GND GND VDD VDD 27 sky130_fd_sc_hd__nor4bb_1
X27 bit_idx.0 comp_in bit_idx.1 2 3 GND GND VDD VDD 28 sky130_fd_sc_hd__o2111ai_1
X28 10 28 GND GND VDD VDD 29 sky130_fd_sc_hd__nor2_1
X29 2 active 23 14 GND GND VDD VDD 30 sky130_fd_sc_hd__a31oi_1
X30 8 13 GND GND VDD VDD 31 sky130_fd_sc_hd__lpflow_inputiso1p_1
X31 cdac_sw.2 30 31 29 GND GND VDD VDD 32 sky130_fd_sc_hd__a31o_1
X32 done 17 GND GND VDD VDD 33 sky130_fd_sc_hd__nor2_1
X33 14 33 GND GND VDD VDD 34 sky130_fd_sc_hd__nor2_1
X34 bit_idx.3 bit_idx.0 bit_idx.1 bit_idx.2 GND GND VDD VDD 35 sky130_fd_sc_hd__nor4b_1
X35 comp_in 27 35 GND GND VDD VDD 36 sky130_fd_sc_hd__a21oi_1
X36 active 27 14 GND GND VDD VDD 37 sky130_fd_sc_hd__a21oi_1
X37 cdac_sw.3 31 37 GND GND VDD VDD 38 sky130_fd_sc_hd__nand3_1
X38 10 36 38 GND GND VDD VDD 39 sky130_fd_sc_hd__o21ai_0
X39 bit_idx.1 bit_idx.2 bit_idx.3 bit_idx.0 GND GND VDD VDD 40 sky130_fd_sc_hd__nor4bb_1
X40 result.9 13 GND GND VDD VDD 41 sky130_fd_sc_hd__nand2_1
X41 40 comp_in GND GND VDD VDD 42 sky130_fd_sc_hd__lpflow_isobufsrc_1
X42 result.9 40 active GND GND VDD VDD 43 sky130_fd_sc_hd__o21ai_0
X43 42 43 41 GND GND VDD VDD 44 sky130_fd_sc_hd__o21ai_0
X44 bit_idx.3 bit_idx.2 active GND GND VDD VDD 45 sky130_fd_sc_hd__nand3b_1
X45 11 45 GND GND VDD VDD 46 sky130_fd_sc_hd__nor2_1
X46 active comp_in 35 46 GND GND VDD VDD 47 sky130_fd_sc_hd__a31oi_1
X47 active 35 14 GND GND VDD VDD 48 sky130_fd_sc_hd__a21oi_1
X48 cdac_sw.4 31 48 GND GND VDD VDD 49 sky130_fd_sc_hd__nand3_1
X49 47 49 GND GND VDD VDD 50 sky130_fd_sc_hd__nand2_1
X50 42 10 4 cdac_sw.9 GND GND VDD VDD 51 sky130_fd_sc_hd__a2bb2oi_1
X51 bit_idx.3 23 40 cdac_sw.9 GND GND VDD VDD 52 sky130_fd_sc_hd__a211oi_1
X52 51 52 15 GND GND VDD VDD 53 sky130_fd_sc_hd__o21ai_0
X53 14 46 GND GND VDD VDD 54 sky130_fd_sc_hd__nor2_1
X54 comp_in 8 46 GND GND VDD VDD 55 sky130_fd_sc_hd__and3_1
X55 22 45 GND GND VDD VDD 56 sky130_fd_sc_hd__nor2_1
X56 cdac_sw.5 31 54 55 56 GND GND VDD VDD 57 sky130_fd_sc_hd__a311o_1
X57 14 56 GND GND VDD VDD 58 sky130_fd_sc_hd__nor2_1
X58 cdac_sw.6 31 GND GND VDD VDD 59 sky130_fd_sc_hd__nand2_1
X59 26 45 GND GND VDD VDD 60 sky130_fd_sc_hd__nor2_1
X60 comp_in 56 60 GND GND VDD VDD 61 sky130_fd_sc_hd__a21oi_1
X61 14 56 59 61 GND GND VDD VDD 62 sky130_fd_sc_hd__o31ai_1
X62 14 60 GND GND VDD VDD 63 sky130_fd_sc_hd__nor2_1
X63 comp_in 60 GND GND VDD VDD 64 sky130_fd_sc_hd__and2_0
X64 2 16 GND GND VDD VDD 65 sky130_fd_sc_hd__nor2_1
X65 cdac_sw.7 31 63 64 65 GND GND VDD VDD 66 sky130_fd_sc_hd__a311o_1
X66 10 15 GND GND VDD VDD 67 sky130_fd_sc_hd__nand2_1
X67 bit_idx.3 16 GND GND VDD VDD 68 sky130_fd_sc_hd__nand2_1
X68 15 68 GND GND VDD VDD 69 sky130_fd_sc_hd__nand2_1
X69 bit_idx.3 comp_in GND GND VDD VDD 70 sky130_fd_sc_hd__nand2_1
X70 bit_idx.3 comp_in 6 40 GND GND VDD VDD 71 sky130_fd_sc_hd__a31oi_1
X71 cdac_sw.8 15 16 GND GND VDD VDD 72 sky130_fd_sc_hd__nand3_1
X72 10 71 72 GND GND VDD VDD 73 sky130_fd_sc_hd__o21ai_0
X73 comp_in 17 18 result.0 GND GND VDD VDD 74 sky130_fd_sc_hd__a22o_1
X74 result.1 12 15 GND GND VDD VDD 75 sky130_fd_sc_hd__nand3_1
X75 4 11 21 75 GND GND VDD VDD 76 sky130_fd_sc_hd__o31ai_1
X76 4 21 22 GND GND VDD VDD 77 sky130_fd_sc_hd__nor3_1
X77 result.2 30 77 GND GND VDD VDD 78 sky130_fd_sc_hd__a21o_1
X78 active comp_in 27 37 result.3 GND GND VDD VDD 79 sky130_fd_sc_hd__a32o_1
X79 active comp_in 35 48 result.4 GND GND VDD VDD 80 sky130_fd_sc_hd__a32o_1
X80 result.5 54 55 GND GND VDD VDD 81 sky130_fd_sc_hd__a21o_1
X81 comp_in 56 58 result.6 GND GND VDD VDD 82 sky130_fd_sc_hd__a22o_1
X82 result.7 63 64 GND GND VDD VDD 83 sky130_fd_sc_hd__a21o_1
X83 result.8 15 GND GND VDD VDD 84 sky130_fd_sc_hd__nand2_1
X84 16 70 84 65 GND GND VDD VDD 85 sky130_fd_sc_hd__o22ai_1
X85 bit_idx.0 9 14 GND GND VDD VDD 86 sky130_fd_sc_hd__nor3_1
X86 bit_idx.0 active 86 GND GND VDD VDD 87 sky130_fd_sc_hd__a21oi_1
X87 bit_idx.1 10 15 GND GND VDD VDD 88 sky130_fd_sc_hd__nand3_1
X88 9 11 22 GND GND VDD VDD 89 sky130_fd_sc_hd__nand3_1
X89 88 89 GND GND VDD VDD 90 sky130_fd_sc_hd__nand2_1
X90 7 20 10 GND GND VDD VDD 91 sky130_fd_sc_hd__a21o_1
X91 3 67 91 GND GND VDD VDD 92 sky130_fd_sc_hd__o21ai_0
X92 rst GND GND VDD VDD 93 sky130_fd_sc_hd__clkinv_1
X93 rst GND GND VDD VDD 94 sky130_fd_sc_hd__clkinv_1
X94 rst GND GND VDD VDD 95 sky130_fd_sc_hd__clkinv_1
X95 rst GND GND VDD VDD 96 sky130_fd_sc_hd__clkinv_1
X96 rst GND GND VDD VDD 97 sky130_fd_sc_hd__clkinv_1
X97 rst GND GND VDD VDD 98 sky130_fd_sc_hd__clkinv_1
X98 rst GND GND VDD VDD 99 sky130_fd_sc_hd__clkinv_1
X99 rst GND GND VDD VDD 100 sky130_fd_sc_hd__clkinv_1
X100 rst GND GND VDD VDD 101 sky130_fd_sc_hd__clkinv_1
X101 rst GND GND VDD VDD 102 sky130_fd_sc_hd__clkinv_1
X102 rst GND GND VDD VDD 103 sky130_fd_sc_hd__clkinv_1
X103 rst GND GND VDD VDD 104 sky130_fd_sc_hd__clkinv_1
X104 rst GND GND VDD VDD 105 sky130_fd_sc_hd__clkinv_1
X105 rst GND GND VDD VDD 106 sky130_fd_sc_hd__clkinv_1
X106 rst GND GND VDD VDD 107 sky130_fd_sc_hd__clkinv_1
X107 rst GND GND VDD VDD 108 sky130_fd_sc_hd__clkinv_1
X108 rst GND GND VDD VDD 109 sky130_fd_sc_hd__clkinv_1
X109 rst GND GND VDD VDD 110 sky130_fd_sc_hd__clkinv_1
X110 rst GND GND VDD VDD 111 sky130_fd_sc_hd__clkinv_1
X111 rst GND GND VDD VDD 112 sky130_fd_sc_hd__clkinv_1
X112 rst GND GND VDD VDD 113 sky130_fd_sc_hd__clkinv_1
X113 rst GND GND VDD VDD 114 sky130_fd_sc_hd__clkinv_1
X114 rst GND GND VDD VDD 115 sky130_fd_sc_hd__clkinv_1
X115 rst GND GND VDD VDD 116 sky130_fd_sc_hd__clkinv_1
X116 rst GND GND VDD VDD 117 sky130_fd_sc_hd__clkinv_1
X117 clkin 87 94 GND GND VDD VDD bit_idx.0 sky130_fd_sc_hd__dfstp_2
X118 clkin 90 93 GND GND VDD VDD bit_idx.1 sky130_fd_sc_hd__dfrtp_1
X119 clkin 92 5 GND GND VDD VDD bit_idx.2 sky130_fd_sc_hd__dfrtp_1
X120 clkin 69 106 GND GND VDD VDD bit_idx.3 sky130_fd_sc_hd__dfstp_2
X121 clkin 19 117 GND GND VDD VDD cdac_sw.0 sky130_fd_sc_hd__dfrtp_1
X122 clkin 25 116 GND GND VDD VDD cdac_sw.1 sky130_fd_sc_hd__dfrtp_1
X123 clkin 32 115 GND GND VDD VDD cdac_sw.2 sky130_fd_sc_hd__dfrtp_1
X124 clkin 39 113 GND GND VDD VDD cdac_sw.3 sky130_fd_sc_hd__dfrtp_1
X125 clkin 50 111 GND GND VDD VDD cdac_sw.4 sky130_fd_sc_hd__dfrtp_1
X126 clkin 57 109 GND GND VDD VDD cdac_sw.5 sky130_fd_sc_hd__dfrtp_1
X127 clkin 62 108 GND GND VDD VDD cdac_sw.6 sky130_fd_sc_hd__dfrtp_1
X128 clkin 66 107 GND GND VDD VDD cdac_sw.7 sky130_fd_sc_hd__dfrtp_1
X129 clkin 73 105 GND GND VDD VDD cdac_sw.8 sky130_fd_sc_hd__dfrtp_1
X130 clkin 53 110 GND GND VDD VDD cdac_sw.9 sky130_fd_sc_hd__dfrtp_1
X131 clkin 74 104 GND GND VDD VDD result.0 sky130_fd_sc_hd__dfrtp_1
X132 clkin 76 102 GND GND VDD VDD result.1 sky130_fd_sc_hd__dfrtp_1
X133 clkin 78 101 GND GND VDD VDD result.2 sky130_fd_sc_hd__dfrtp_1
X134 clkin 79 100 GND GND VDD VDD result.3 sky130_fd_sc_hd__dfrtp_1
X135 clkin 80 99 GND GND VDD VDD result.4 sky130_fd_sc_hd__dfrtp_1
X136 clkin 81 98 GND GND VDD VDD result.5 sky130_fd_sc_hd__dfrtp_1
X137 clkin 82 97 GND GND VDD VDD result.6 sky130_fd_sc_hd__dfrtp_1
X138 clkin 83 96 GND GND VDD VDD result.7 sky130_fd_sc_hd__dfrtp_1
X139 clkin 85 95 GND GND VDD VDD result.8 sky130_fd_sc_hd__dfrtp_1
X140 clkin 44 112 GND GND VDD VDD result.9 sky130_fd_sc_hd__dfrtp_1
X141 clkin 34 114 GND GND VDD VDD done sky130_fd_sc_hd__dfrtp_1
X142 clkin 67 103 GND GND VDD VDD active sky130_fd_sc_hd__dfrtp_1

************************
* end of SPICE netlist *
************************

.ends sar_logic

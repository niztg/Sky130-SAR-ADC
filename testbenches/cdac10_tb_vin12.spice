* Testbench for the REAL 10-bit cdac.spice (bottom-plate sampling,
* no dummy compensation switch -- clean baseline matching the version
* the offset was originally measured on).
*
* Extends the 0.3V/0.6V/0.9V characterization in cdac10_tb_vin03/06/09
* .spice up to vin=1.2V, to test whether the top-plate reset
* feedthrough kick keeps growing steeply enough to explain the -54 LSB
* residual seen in the full-ADC testbench at vin=1.5V post n-well-fix.
*
* Unlike the original 0.3-0.9V versions, this one pulls bootstrapped_
* switch via cdac.spice's own .include (now pointing at the n-well-fixed
* bootstrapped_switch.spice) rather than an inline old/unfixed copy --
* needed at this vin range so any undersampling contamination from the
* (now-fixed) bootstrap bug doesn't get mixed back into this measurement.
*
* Predicted vdac_postsample = vcm - vin  (before any code switching)
*   vin=1.2V -> predicted -0.300V
*
* Predicted vdac_D0/D512/D1023 = (vcm - vin) + vref*D/1024
*   D512 predicted: 0.6000V
*   D1023 predicted: 1.4982V
* CAVEAT: D=1023 may approach/exceed VDD depending on vin, expect
* saturation/clipping there -- it's a stress test, not a clean linear
* check (same caveat as the original single-vin version of this file).
*
* .ic/UIC cold-start conditions are tied to {VIN_TEST} so this run
* starts cleanly at vdac=0.9V (reset target) and vin_s/bp*=VIN_TEST,
* avoiding the DC-operating-point startup artifact found and fixed in
* the original single-vin version of this testbench.

.lib /Users/nizansari/.volare/sky130A/libs.tech/ngspice/sky130.lib.spice tt
.include "cdac.spice"

.param VIN_TEST = 1.2

Vvdd vdd 0 DC 1.8
Vvref vref 0 DC 1.8
Vvcm vcm 0 DC 0.9
Vvin vin 0 DC {VIN_TEST}

* phi_s: one-shot sample pulse, 300ns wide (matches measured 156.8ns
* 10-bit settling time with ~2x margin, same as sar_adc_tb.spice)
Vphi_s phi_s 0 PULSE(0 1.8 0 1n 1n 300n 10u)

* Bit sources: held at 0 during sample, then stepped through D=0, D=512,
* D=1023 -- each held flat for 500ns with sharp (1ns) transitions.
Vsw9 cdac_sw9 0 PWL(0 0  599n 0  600n 0  1099n 0  1100n 1  1599n 1  1600n 1  2099n 1)
Vsw8 cdac_sw8 0 PWL(0 0  1599n 0  1600n 1  2099n 1)
Vsw7 cdac_sw7 0 PWL(0 0  1599n 0  1600n 1  2099n 1)
Vsw6 cdac_sw6 0 PWL(0 0  1599n 0  1600n 1  2099n 1)
Vsw5 cdac_sw5 0 PWL(0 0  1599n 0  1600n 1  2099n 1)
Vsw4 cdac_sw4 0 PWL(0 0  1599n 0  1600n 1  2099n 1)
Vsw3 cdac_sw3 0 PWL(0 0  1599n 0  1600n 1  2099n 1)
Vsw2 cdac_sw2 0 PWL(0 0  1599n 0  1600n 1  2099n 1)
Vsw1 cdac_sw1 0 PWL(0 0  1599n 0  1600n 1  2099n 1)
Vsw0 cdac_sw0 0 PWL(0 0  1599n 0  1600n 1  2099n 1)

Xcdac vdac cdac_sw9 cdac_sw8 cdac_sw7 cdac_sw6 cdac_sw5
+      cdac_sw4 cdac_sw3 cdac_sw2 cdac_sw1 cdac_sw0
+      vref vdd gnd vin phi_s vcm cdac

.ic v(vdac)=0.9 v(xcdac.vin_s)={VIN_TEST} v(xcdac.bp9)={VIN_TEST} v(xcdac.bp8)={VIN_TEST} v(xcdac.bp7)={VIN_TEST} v(xcdac.bp6)={VIN_TEST}
+   v(xcdac.bp5)={VIN_TEST} v(xcdac.bp4)={VIN_TEST} v(xcdac.bp3)={VIN_TEST} v(xcdac.bp2)={VIN_TEST} v(xcdac.bp1)={VIN_TEST} v(xcdac.bp0)={VIN_TEST} v(xcdac.bpt)={VIN_TEST}

.tran 100p 2.1u UIC

.probe v(vdac) v(phi_s) v(cdac_sw9) v(cdac_sw0)

* Checkpoints matching the 0.3/0.6/0.9V versions, to extend the same
* kick-vs-vin trend up through 1.2V:
.meas tran vdac_after_sample find v(vdac) at=299n
.meas tran vdac_postsample   find v(vdac) at=599n

.meas tran vdac_D0    find v(vdac) at=1050n
.meas tran vdac_D512  find v(vdac) at=1550n
.meas tran vdac_D1023 find v(vdac) at=2050n

.end

* ============================================================
* ISOLATION TEST 2 (fixed) : comparator capture chain
* ------------------------------------------------------------
* Same forced vdac sequence into TWO capture chains:
*   comp_in      = bare comp_y -> DFF            (the current design)
*   comp_in_srl  = comp_x/comp_y -> SR latch -> DFF   (proposed fix)
*
* vdac=1.2 (>vcm=0.9): clear -> expect 0
* vdac=0.75(<vcm)    : keep  -> expect 1
* Expected captured sequence (both): c0 c1 c2 c3 = 0 1 0 1
* If comp_in's first value is wrong but comp_in_srl is right,
* the SR latch is the fix.
* ============================================================
.lib /Users/nizansari/.volare/sky130A/libs.tech/ngspice/sky130.lib.spice tt
.include "/Users/nizansari/.volare/sky130A/libs.ref/sky130_fd_sc_hd/spice/sky130_fd_sc_hd.spice"

.subckt strongarm_comparator VDD X Y CLK VIN2 VIN1
XS1 P CLK VDD VDD sky130_fd_pr__pfet_01v8 L=0.15 W=1 nf=1 ad='int((nf+1)/2) * W/nf * 0.29' as='int((nf+2)/2) * W/nf * 0.29' pd='2*int((nf+1)/2) * (W/nf + 0.29)' ps='2*int((nf+2)/2) * (W/nf + 0.29)' nrd='0.29 / W' nrs='0.29 / W' sa=0 sb=0 sd=0 mult=1
XS3 X CLK VDD VDD sky130_fd_pr__pfet_01v8 L=0.15 W=1 nf=1 ad='int((nf+1)/2) * W/nf * 0.29' as='int((nf+2)/2) * W/nf * 0.29' pd='2*int((nf+1)/2) * (W/nf + 0.29)' ps='2*int((nf+2)/2) * (W/nf + 0.29)' nrd='0.29 / W' nrs='0.29 / W' sa=0 sb=0 sd=0 mult=1
XM5 X Y VDD VDD sky130_fd_pr__pfet_01v8 L=0.15 W=4 nf=1 ad='int((nf+1)/2) * W/nf * 0.29' as='int((nf+2)/2) * W/nf * 0.29' pd='2*int((nf+1)/2) * (W/nf + 0.29)' ps='2*int((nf+2)/2) * (W/nf + 0.29)' nrd='0.29 / W' nrs='0.29 / W' sa=0 sb=0 sd=0 mult=1
XM6 Y X VDD VDD sky130_fd_pr__pfet_01v8 L=0.15 W=4 nf=1 ad='int((nf+1)/2) * W/nf * 0.29' as='int((nf+2)/2) * W/nf * 0.29' pd='2*int((nf+1)/2) * (W/nf + 0.29)' ps='2*int((nf+2)/2) * (W/nf + 0.29)' nrd='0.29 / W' nrs='0.29 / W' sa=0 sb=0 sd=0 mult=1
XS4 Y CLK VDD VDD sky130_fd_pr__pfet_01v8 L=0.15 W=1 nf=1 ad='int((nf+1)/2) * W/nf * 0.29' as='int((nf+2)/2) * W/nf * 0.29' pd='2*int((nf+1)/2) * (W/nf + 0.29)' ps='2*int((nf+2)/2) * (W/nf + 0.29)' nrd='0.29 / W' nrs='0.29 / W' sa=0 sb=0 sd=0 mult=1
XS2 Q CLK VDD VDD sky130_fd_pr__pfet_01v8 L=0.15 W=1 nf=1 ad='int((nf+1)/2) * W/nf * 0.29' as='int((nf+2)/2) * W/nf * 0.29' pd='2*int((nf+1)/2) * (W/nf + 0.29)' ps='2*int((nf+2)/2) * (W/nf + 0.29)' nrd='0.29 / W' nrs='0.29 / W' sa=0 sb=0 sd=0 mult=1
XM4 Y X Q 0 sky130_fd_pr__nfet_01v8 L=0.15 W=4 nf=1 ad='int((nf+1)/2) * W/nf * 0.29' as='int((nf+2)/2) * W/nf * 0.29' pd='2*int((nf+1)/2) * (W/nf + 0.29)' ps='2*int((nf+2)/2) * (W/nf + 0.29)' nrd='0.29 / W' nrs='0.29 / W' sa=0 sb=0 sd=0 mult=1
XM3 X Y P 0 sky130_fd_pr__nfet_01v8 L=0.15 W=4 nf=1 ad='int((nf+1)/2) * W/nf * 0.29' as='int((nf+2)/2) * W/nf * 0.29' pd='2*int((nf+1)/2) * (W/nf + 0.29)' ps='2*int((nf+2)/2) * (W/nf + 0.29)' nrd='0.29 / W' nrs='0.29 / W' sa=0 sb=0 sd=0 mult=1
XM1 P VIN1 net1 0 sky130_fd_pr__nfet_01v8 L=0.15 W=8 nf=1 ad='int((nf+1)/2) * W/nf * 0.29' as='int((nf+2)/2) * W/nf * 0.29' pd='2*int((nf+1)/2) * (W/nf + 0.29)' ps='2*int((nf+2)/2) * (W/nf + 0.29)' nrd='0.29 / W' nrs='0.29 / W' sa=0 sb=0 sd=0 mult=1
XM2 Q VIN2 net1 0 sky130_fd_pr__nfet_01v8 L=0.15 W=8 nf=1 ad='int((nf+1)/2) * W/nf * 0.29' as='int((nf+2)/2) * W/nf * 0.29' pd='2*int((nf+1)/2) * (W/nf + 0.29)' ps='2*int((nf+2)/2) * (W/nf + 0.29)' nrd='0.29 / W' nrs='0.29 / W' sa=0 sb=0 sd=0 mult=1
XM7 net1 CLK 0 0 sky130_fd_pr__nfet_01v8 L=0.15 W=2 nf=1 ad='int((nf+1)/2) * W/nf * 0.29' as='int((nf+2)/2) * W/nf * 0.29' pd='2*int((nf+1)/2) * (W/nf + 0.29)' ps='2*int((nf+2)/2) * (W/nf + 0.29)' nrd='0.29 / W' nrs='0.29 / W' sa=0 sb=0 sd=0 mult=1
.ends strongarm_comparator

Vvdd vdd 0 DC 1.8
Vvcm vcm 0 DC 0.9

* vdac square: 1.2 then 0.75 then 1.2 then 0.75, switching during clk-low
Vvdac vdac 0 PWL(0 1.2  1.6u 1.2  1.61u 0.75  3.6u 0.75  3.61u 1.2
+                5.6u 1.2  5.61u 0.75  7.6u 0.75  8u 0.75)

Vclk    clk    0 PULSE(0 1.8 500n 1n 1n 990n 2000n)
Vclkbar clkbar 0 PULSE(1.8 0 500n 1n 1n 990n 2000n)

* VIN2=vdac, VIN1=vcm
Xcmp vdd comp_x comp_y clk vdac vcm strongarm_comparator

* ---- chain A: bare comp_y captured on clk-falling (current design) ----
Xdff clkbar comp_y 0 0 vdd vdd comp_in sky130_fd_sc_hd__dfxtp_1

* ---- chain B: SR latch holds the decision through precharge, then capture --
*   keep  (vdac<vcm): comp_x=0,comp_y=1 -> Q=1
*   clear (vdac>vcm): comp_x=1,comp_y=0 -> Q=0
Xsr_q    comp_x sr_qbar 0 0 vdd vdd sr_q    sky130_fd_sc_hd__nand2_1
Xsr_qbar comp_y sr_q    0 0 vdd vdd sr_qbar sky130_fd_sc_hd__nand2_1
Xdff_srl clkbar sr_q 0 0 vdd vdd comp_in_srl sky130_fd_sc_hd__dfxtp_1

.tran 200p 8u
.probe v(vdac) v(comp_x) v(comp_y) v(comp_in) v(sr_q) v(comp_in_srl) v(clk)

.meas tran c0     find v(comp_in)     at=2.4u
.meas tran c1     find v(comp_in)     at=4.4u
.meas tran c2     find v(comp_in)     at=6.4u
.meas tran c3     find v(comp_in)     at=7.9u
.meas tran c0_srl find v(comp_in_srl) at=2.4u
.meas tran c1_srl find v(comp_in_srl) at=4.4u
.meas tran c2_srl find v(comp_in_srl) at=6.4u
.meas tran c3_srl find v(comp_in_srl) at=7.9u
.end
